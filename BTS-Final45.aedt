# Ansys Electronics Desktop project, version 2022.1
materials:
  vacuum: permittivity=1
  pec: conductivity=1e+30
  Teflon (tm): permittivity=2.1 dielectric_loss_tangent=0.001
  air: permittivity=1.0006 permeability=1.0000004

design HFSSDesign1 (HFSS, DrivenModal, model units mm)
options: Calculate_Lossy_Dielectrics Save_Adaptive_support_files
variables:
  RatioElips = 1.5
  L1 = 9mm
  Zref = 30mm
  AL = 5.75mm
geometry:
  Rectangle2 = rectangle(corner=(-4mm, -4mm, 91mm), z_size=-91mm, x_size=8mm)
  Rectangle3 = rectangle(corner=(-4mm, 4mm, 91mm), z_size=-90mm, x_size=8mm)
  Rectangle4 = rectangle(corner=(-10mm, -10.5mm, 0mm), x_size=21mm, y_size=21mm)
  Rectangle5 = rectangle(corner=(-10mm, -10.5mm, 0mm), z_size=93mm, x_size=21mm)
  Rectangle5_1 = Rectangle5.duplicate_mirror(point=(0mm, 0mm, 91mm), normal=(0mm, 1mm, 0mm))
  Rectangle8 = rectangle(corner=((-320/2) mm, (-320/2) mm, 0mm), x_size=320mm, y_size=320mm)
  Cylinder2 [Teflon (tm)] = cylinder(axis=Y, base_centre=(0mm, 10.5mm, 1mm), radius=1.7mm, height=5.4mm)
  Cylinder3 [pec] = cylinder(axis=Y, base_centre=(0mm, 10.5mm, 1mm), radius=0.5mm, height=5.4mm)
  Cylinder4 [pec] = cylinder(axis=Y, base_centre=(0mm, 15.9mm, 1mm), radius=1.7mm, height=0.5mm)
  [Cylinder3, Cylinder4, Cylinder2].move(0mm, 0mm, 4mm)
  Circle1 = circle(normal=Y, centre=(0mm, 10.5mm, 5mm), radius=1.7mm)
  Rectangle8.move(0mm, 0mm, -0.02mm)
  Box1 [air] = box(corner=(-250mm, -250mm, -20mm), size=(500mm, 500mm, 400mm))
  [Rectangle3, Rectangle2].move(0mm, 0mm, 2mm)
  Rectangle3.move(0mm, 3mm, 0mm)
  Rectangle2.move(0mm, -3mm, 0mm)
  coordinate_system RelativeCS1 = origin=(0.5mm, 47.5mm, 93mm) x=(1mm, 0mm, 0mm) y=(0mm, 1mm, 0mm)
  coordinate_system RelativeCS2 = origin=(0mm, 17.67767mm, -17.67767mm) x=(1mm, 0mm, 0mm) y=(0mm, 1mm, 0mm) in RelativeCS1
  coordinate_system RelativeCS3 = origin=(0.5mm, -48.349365mm, 93mm) x=(1mm, 0mm, 0mm) y=(0mm, 1mm, 0mm)
  coordinate_system RelativeCS4 = origin=(0mm, -25mm, 0mm) x=(1mm, 0mm, 0mm) y=(0mm, 1mm, 0mm) in RelativeCS3
  coordinate_system RelativeCS5 = origin=(0mm, 121.69873mm, 0mm) x=(1mm, 0mm, 0mm) y=(0mm, 1mm, 0mm) in RelativeCS4
  coordinate_system RelativeCS6 = origin=(0mm, 25mm, 0mm) x=(1mm, 0mm, 0mm) y=(0mm, 1mm, 0mm) in RelativeCS5
  coordinate_system RelativeCS7 = origin=(0mm, -146.69873mm, 0mm) x=(1mm, 0mm, 0mm) y=(0mm, 1mm, 0mm) in RelativeCS6
  coordinate_system RelativeCS8 = origin=(0mm, 146.69873mm, 0mm) x=(1mm, 0mm, 0mm) y=(0mm, 1mm, 0mm) in RelativeCS7
  coordinate_system RelativeCS9 = origin=(0.5mm, -10.5mm, 93mm) x=(1mm, 0mm, 0mm) y=(0mm, 1mm, 0mm)
  coordinate_system RelativeCS10 = origin=(-19.6mm, 10.5mm, 0mm) x=(1mm, 0mm, 0mm) y=(0mm, 1mm, 0mm) in RelativeCS9
  coordinate_system RelativeCS11 = origin=(19.6mm, -73.349365mm, 0mm) x=(1mm, 0mm, 0mm) y=(0mm, 1mm, 0mm) in RelativeCS10
  coordinate_system RelativeCS12 = origin=(-25.1mm, 73.349365mm, 0mm) x=(1mm, 0mm, 0mm) y=(0mm, 1mm, 0mm) in RelativeCS11
  coordinate_system RelativeCS13 = origin=(25.1mm, -73.349365mm, 0mm) x=(1mm, 0mm, 0mm) y=(0mm, 1mm, 0mm) in RelativeCS12
  Rectangle24 = rectangle(corner=(-4mm, 7mm, 3mm), x_size=8mm, y_size=-5mm)
  [Cylinder3, Circle1, Cylinder2, Cylinder4].rotate(axis=X, angle=90deg)
  [Cylinder3, Circle1, Cylinder2, Cylinder4].rotate(axis=Y, angle=180deg)
  [Cylinder3, Circle1, Cylinder2, Cylinder4].move(0mm, 9.5mm, 10mm)
  Cylinder5 [pec] = cylinder(axis=Z, base_centre=(0mm, 4.5mm, 3mm), radius=0.5mm, height=-2.5mm)
  [Cylinder2, Cylinder3, Cylinder4, Circle1].move(0mm, 0mm, 0.5mm)
  Rectangle4.subtract(Circle1)
  Circle2 = circle(normal=Z, centre=(0mm, 4.5mm, 0mm), radius=2mm)
  Circle2.move(0mm, 0mm, -0.02mm)
  Rectangle8.subtract(Circle2)
  Rectangle25 = rectangle(corner=(4mm, -7mm, 2mm), z_size=5mm, x_size=-12mm)
  Rectangle2.subtract(Rectangle25)
  coordinate_system RelativeCS14 = origin=(0mm, -7mm, 93mm) x=(1mm, 0mm, 0mm) y=(0mm, 1mm, 0mm)
  coordinate_system RelativeCS15 = origin=(0mm, 7mm, 0mm) x=(1mm, 0mm, 0mm) y=(0mm, 1mm, 0mm) in RelativeCS14
  coordinate_system RelativeCS16 = origin=(-170mm, -170mm, -58.02mm) x=(1mm, 0mm, 0mm) y=(0mm, 1mm, 0mm) in RelativeCS15
  coordinate_system RelativeCS17 = origin=(0mm, 340mm, 0mm) x=(1mm, 0mm, 0mm) y=(0mm, 1mm, 0mm) in RelativeCS16
  Ellipse1 = ellipse(normal=Z, centre=(-2.5322511mm, -84.277334mm, 93mm), major_radius=135mm, ratio=0.7, segments=4)
  Ellipse1.move(3.0322511mm, 0.27733412mm, 0mm)
  coordinate_system RelativeCS18 = origin=(-35mm, -10.5mm, 93mm) x=(1mm, 0mm, 0mm) y=(0mm, 1mm, 0mm)
  Ellipse1.split(plane=ZX, keep=Both) in RelativeCS18
  coordinate_system RelativeCS19 = origin=(-60mm, -120mm, 0mm) x=(1mm, 0mm, 0mm) y=(0mm, 1mm, 0mm) in RelativeCS18
  Ellipse1_Split1 = Ellipse1.split(plane=YZ, keep=Both) in RelativeCS19
  Ellipse1.delete()
  coordinate_system RelativeCS20 = origin=(95.5mm, -48mm, 0mm) x=(1mm, 0mm, 0mm) y=(0mm, 1mm, 0mm) in RelativeCS19
  coordinate_system RelativeCS21 = origin=(95.5mm, 66.85mm, 0mm) x=(1mm, 0mm, 0mm) y=(0mm, 1mm, 0mm) in RelativeCS20
  Ellipse1_Split1.split(plane=YZ, keep=Both) in RelativeCS21
  coordinate_system RelativeCS22 = origin=(-170mm, -170mm, 34.98mm) x=(1mm, 0mm, 0mm) y=(0mm, 1mm, 0mm)
  Ellipse1_Split1_Split1 = Ellipse1_Split1.split(plane=ZX, keep=Both) in RelativeCS22
  Ellipse1_Split1.delete()
  Ellipse1_Split1_Split1_1 = Ellipse1_Split1_Split1.duplicate_mirror(point=(0mm, 0mm, 93mm), normal=(0mm, 1mm, 0mm))
  Ellipse2 = ellipse(normal=Z, centre=(0.5mm, -170mm, 93mm), major_radius=41mm, ratio=RatioElips)
  Ellipse2_1 = Ellipse2.duplicate_mirror(point=(0mm, 0mm, 93mm), normal=(0mm, 1mm, 0mm))
  Ellipse1_Split1_Split1.subtract(Ellipse2)
  Ellipse1_Split1_Split1_1.subtract(Ellipse2_1)
  Rectangle29 = rectangle(corner=(-95mm, -111.65mm, 93mm), x_size=-L1, y_size=55.3mm)
  Rectangle29_1 = Rectangle29.duplicate_mirror(point=(0mm, 0mm, 93mm), normal=(1mm, 0mm, 0mm))
  Rectangle29_1.move(1mm, -7.1054274e-14mm, 0mm)
  Rectangle29_1_1 = Rectangle29_1.duplicate_mirror(point=(0mm, 0mm, 93mm), normal=(0mm, 1mm, 0mm))
  Rectangle29_2 = Rectangle29.duplicate_mirror(point=(0mm, 0mm, 93mm), normal=(0mm, 1mm, 0mm))
  Ellipse1_Split1_Split1.unite(Rectangle29, Rectangle29_1)
  Ellipse1_Split1_Split1_1.unite(Rectangle29_2, Rectangle29_1_1)
  coordinate_system RelativeCS23 = origin=(-105mm, -84mm, 93mm) x=(1mm, 0mm, 0mm) y=(0mm, 1mm, 0mm)
  coordinate_system RelativeCS24 = origin=(0mm, 0mm, 93mm) x=(1mm, 0mm, 0mm) y=(0mm, 1mm, 0mm)
  Rectangle31 = rectangle(corner=(4mm, -7mm, 7mm), z_size=5mm, x_size=-10mm)
  Rectangle2.subtract(Rectangle31)
  coordinate_system RelativeCS25 = origin=(0.5mm, -108.5mm, 93mm) x=(1mm, 0mm, 0mm) y=(0mm, 1mm, 0mm)
  coordinate_system RelativeCS26 = origin=(-175.5mm, 108.5mm, -93.02mm) x=(1mm, 0mm, 0mm) y=(0mm, 1mm, 0mm) in RelativeCS25
  coordinate_system RelativeCS27 = origin=(175.5mm, -116.22727mm, 93.02mm) x=(1mm, 0mm, 0mm) y=(0mm, 1mm, 0mm) in RelativeCS26
  coordinate_system RelativeCS28 = origin=(-10.5mm, 116.22727mm, -93mm) x=(1mm, 0mm, 0mm) y=(0mm, 1mm, 0mm) in RelativeCS27
  [Rectangle24, Cylinder5].move(1.7763568e-15mm, 8.8817842e-16mm, -0.5mm) in RelativeCS28
  Rectangle32 = rectangle(corner=(6mm, 7mm, 3mm), z_size=-0.5mm, x_size=8mm) in RelativeCS28
  Rectangle3.unite(Rectangle32)
  coordinate_system RelativeCS29 = origin=(-150mm, 0mm, -0.02mm) x=(1mm, 0mm, 0mm) y=(0mm, 1mm, 0mm) in RelativeCS28
  coordinate_system RelativeCS30 = origin=(160mm, 160mm, 0mm) x=(1mm, 0mm, 0mm) y=(0mm, 1mm, 0mm) in RelativeCS29
  coordinate_system RelativeCS31 = origin=(0mm, -320mm, 0mm) x=(1mm, 0mm, 0mm) y=(0mm, 1mm, 0mm) in RelativeCS30
  coordinate_system RelativeCS32 = origin=(-160mm, 160mm, 0mm) x=(1mm, 0mm, 0mm) y=(0mm, 1mm, 0mm) in RelativeCS31
  coordinate_system RelativeCS33 = origin=(160.5mm, -130mm, 93.02mm) x=(1mm, 0mm, 0mm) y=(0mm, 1mm, 0mm) in RelativeCS32
  coordinate_system RelativeCS34 = origin=(-160.5mm, 130mm, -93.02mm) x=(1mm, 0mm, 0mm) y=(0mm, 1mm, 0mm) in RelativeCS33
  Rectangle33 = rectangle(corner=(160mm, -7mm, 93.02mm), x_size=-AL, y_size=14mm) in RelativeCS34
  coordinate_system RelativeCS35 = origin=(160mm, -7mm, 93.02mm) x=(1mm, 0mm, 0mm) y=(0mm, 1mm, 0mm) in RelativeCS34
  Rectangle33_1 = Rectangle33.duplicate_mirror(point=(0mm, 0mm, 0mm), normal=(1mm, 0mm, 0mm)) in RelativeCS35
  Rectangle33.unite(Rectangle33_1)
  Polyline2 = polyline(xyz in mm: (160, -160, -0.02) (240.41631, -240.41631, 35) (240.41631, 240.41631, 35) (160, 160, -0.02) (160, -160, -0.02), closed, covered)
  Polyline2_1 = Polyline2.duplicate_around_axis(axis=Z, angle=90deg, total=2)
  Polyline2_2 = Polyline2.duplicate_around_axis(axis=Z, angle=180deg, total=2)
  Polyline2_1_1 = Polyline2_1.duplicate_around_axis(axis=Z, angle=180deg, total=2)
  Rectangle34 = rectangle(corner=(240.41631mm, -240.41631mm, 35mm), z_size=35mm, x_size=-240.41631mm)
  coordinate_system RelativeCS36 = origin=(0mm, -240.41631mm, 35mm) x=(1mm, 0mm, 0mm) y=(0mm, 1mm, 0mm)
  Rectangle34_1 = Rectangle34.duplicate_mirror(point=(0mm, 0mm, 0mm), normal=(1mm, 0mm, 0mm)) in RelativeCS36
  Rectangle34.unite(Rectangle34_1)
  Rectangle34_2 = Rectangle34.duplicate_around_axis(axis=Z, angle=180deg, total=2)
  Rectangle34_3 = Rectangle34.duplicate_around_axis(axis=Z, angle=90deg, total=2)
  Rectangle34_2_1 = Rectangle34_2.duplicate_around_axis(axis=Z, angle=90deg, total=2)
  coordinate_system RelativeCS37 = origin=(50mm, -450mm, 0mm) x=(1mm, 0mm, 0mm) y=(0mm, 1mm, 0mm)
boundaries and excitations:
  PerfE1: Perfect E Objects=Rectangle8
  PerfE2: Perfect E Objects=[Rectangle4, Rectangle5, Rectangle5_1]
  PerfE4: Perfect E Objects=[Rectangle3, Rectangle2]
  PerfE5: Perfect E Faces=Cylinder2.face(1 of 3)
  Rad1: Radiation Objects=Box1
  PerfE8: Perfect E Objects=Rectangle24
  PerfE9: Perfect E Objects=[Ellipse1_Split1_Split1, Ellipse1_Split1_Split1_1]
  PerfE10: Perfect E Objects=Rectangle33
  PerfE11: Perfect E Objects=[Polyline2_1_1, Polyline2_2, Polyline2_1, Polyline2]
  PerfE12: Perfect E Objects=[Rectangle34, Rectangle34_2, Rectangle34_2_1, Rectangle34_3]
  1: Wave Port Faces=Cylinder2.face(3 of 3) NumModes=1 Modes{Mode1{CharImp=Zpi}}
setups:
  Setup1: HfssDriven Frequency=0.85GHz MaxDeltaS=0.02 MaximumPasses=15 MinimumPasses=1 MinimumConvergedPasses=1 PercentRefinement=30 BasisOrder=1 PortAccuracy=2 DrivenSolverType="Direct Solver"
    sweep Sweep: 0.4GHz to 1.4GHz step 0.001GHz; Type=Fast SaveFields
source amplitudes:
  1:1: 1W 0deg
radiation setups:
  Infinite Sphere1: Infinite Sphere Theta=-180deg..180deg step 1deg Phi=0deg..360deg step 1deg
reports:
  XY Plot 1: dB(S(1,1)) vs Freq on Setup1 : Sweep; markers m1 at 0.594GHz, m2 at 1.228GHz, m3 at 1.043GHz
  VSWR Plot 1: VSWR(1) vs Freq on Setup1 : Sweep
  Antenna Params Plot 1: dB(PeakGain) vs Freq on Setup1 : Sweep [Freq=0.58GHz,0.63GHz,0.68GHz,0.73GHz,0.78GHz,0.83GHz,0.88GHz,0.93GHz,0.98GHz,1.03GHz,1.08GHz,1.13GHz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]
  Gain Plot 1: dB(GainPhi), dB(GainTheta) vs Theta on Setup1 : Sweep, Infinite Sphere1 [Phi=0deg,90deg Freq=0.7GHz,0.85GHz,0.95GHz]
  Gain Plot 850 MHz: dB(GainTotal) vs Phi, Theta on Setup1 : Sweep, Infinite Sphere1 [Freq=0.85GHz]
  Gain Plot 700 MHz: dB(GainTotal) vs Phi, Theta on Setup1 : Sweep, Infinite Sphere1 [Freq=0.7GHz]
  Gain Plot 950 MHz: dB(GainTotal) vs Phi, Theta on Setup1 : Sweep, Infinite Sphere1 [Freq=0.95GHz]
